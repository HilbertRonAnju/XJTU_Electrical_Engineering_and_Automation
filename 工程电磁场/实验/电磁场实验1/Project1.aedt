# Ansys Electronics Desktop project, version 2018.0
materials:
  vacuum: permittivity=1
  air: permittivity=1.0006 permeability=1.0000004

design Maxwell2DDesign1 (Maxwell 2D, Electrostatic, XY geometry, model units cm)
geometry:
  jinshucao [air] = rectangle(corner=(0cm, 0cm, 0cm), x_size=40cm, y_size=20cm)
  Region [vacuum] = region(percentage_offset: +X=100, -X=100, +Y=100, -Y=100, +Z=0, -Z=0)
  point Point1 = (10cm, 10cm, 0cm)
boundaries and excitations:
  Balloon1: Balloon Edges=Region.edge(all 4) IsOfTypeVoltage=true
  Voltage1: Voltage Edges=jinshucao.edge(y opposite corner) Value=100V
mesh:
  initial mesh: MeshMethod=AnsoftTAU
setups:
  Setup1: Electrostatic MaximumPasses=10 MinimumPasses=2 MinimumConvergedPasses=1 PercentRefinement=30 PercentError=1 NonLinearResidual=0.001
reports:
  Calculator Expressions Table 1: Voltage vs X on Setup1 : LastAdaptive
  Calculator Expressions Table 2: Mag_E vs X on Setup1 : LastAdaptive
